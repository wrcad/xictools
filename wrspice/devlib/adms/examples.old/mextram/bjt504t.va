`include "frontdef.inc"
`define  SELFHEATING
`define  SUBSTRATE

module bjt504tva (c, b, e, s, dt);

  // External ports
     inout c, b, e, s, dt;

     electrical e, b, c, s;
     electrical dt;

  // Internal nodes
     electrical e1, b1, b2, c1, c2, c3, c4;
     electrical noi; // For correlated noise implementation

`include "parameters.inc"
`include "variables.inc"
`include "opvars.inc"

analog begin

`include "initialize.inc"
`include "tscaling.inc"
`include "evaluate.inc"
`include "opinfo.inc"

// The following can be used to print OP-info to std out:
// `include "op_print.inc"

end  // analog

endmodule
