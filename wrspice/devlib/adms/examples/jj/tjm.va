/*========================================================================*
 *                                                                        *
 *  Whiteley Research Inc, Sunnyvale, CA USA 2016, http://wrcad.com       *
 *                                                                        *
 *   THE SOFTWARE IS PROVIDED "AS IS", WITHOUT WARRANTY OF ANY KIND,      *
 *   EXPRESS OR IMPLIED, INCLUDING BUT NOT LIMITED TO THE WARRANTIES      *
 *   OF MERCHANTABILITY, FITNESS FOR A PARTICULAR PURPOSE AND NON-        *
 *   INFRINGEMENT.  IN NO EVENT SHALL STEPHEN R. WHITELEY OR WHITELEY     *
 *   RESEARCH INC. BE LIABLE FOR ANY CLAIM, DAMAGES OR OTHER LIABILITY,   *
 *   WHETHER IN AN ACTION OF CONTRACT, TORT OR OTHERWISE, ARISING FROM,   *
 *   OUT OF OR IN CONNECTION WITH THE SOFTWARE OR THE USE OR OTHER        *
 *   DEALINGS IN THE SOFTWARE.                                            *
 *                                                                        *
 *   Licensed under the Apache License, Version 2.0 (the "License");      *
 *   you may not use this file except in compliance with the License.     *
 *   You may obtain a copy of the License at                              *
 *                                                                        *
 *        http://www.apache.org/licenses/LICENSE-2.0                      *
 *                                                                        *
 *   Unless required by applicable law or agreed to in writing, software  *
 *   distributed under the License is distributed on an "AS IS" BASIS,    *
 *   WITHOUT WARRANTIES OR CONDITIONS OF ANY KIND, either express or      *
 *   implied. See the License for the specific language governing         *
 *   permissions and limitations under the License.                       *
 *                                                                        *
 *========================================================================*
 $Id:$
 *========================================================================*/

// SuperTools Notice ------------------------------------------------------
//
//   GOVERNMENT PURPOSE RIGHTS
//
//   Contract No. W911NF-17-9-0001
//
//   Contractor Name: Synopsys Inc.
//
//   Contractor Address: 690 E Middlefield Rd, Mountain View, CA 94043-4010
//
//   Expiration Date: perpetual-no-expiration
//
//   The Government's rights to use, modify, reproduce, release,
//   perform, display, or disclose this software are restricted by
//   paragraph (b)(2) of the Rights in Technical Data-Noncommercial
//   Items clause contained in the above identified contract.  No
//   restrictions apply after the expiration date shown above.  Any
//   reproduction of technical data or portions thereof marked with this
//   legend must also reproduce the markings.
//-------------------------------------------------------------------------

// Version 0.1, July 30, 2021 (original release)
//
// Stephen R. Whiteley          stevew@wrcad.com, whiteley@synopsys.com
// Whiteley Research Inc.       http://wrcad.com
//
// MODULE: tjm (node_plus, node_minus, node_phase)
//
// The optional phase node provides the junction phase (in radians)
// but should have no other connections.
//
// To use the model:
// 1.  Before compiling, adjust electrical parameters to your target
//     process.  This is the MIT-LL SFQ5EE process by default.
// 2.  Load the model into your simulator before use.
// 3.  Use the "ics" instance parameter to set the desired critical
//     current.  Changing ics (or area) scales capacitance and
//     conductances as well as critical current.  Giving ics is equivalent
//     to area=ics/icrit (use of area is deprecated).
// 4.  Use vshunt most conveniently for SFQ circuits, avoids the need
//     for an external shunt resistor.
// 5.  You may have to use a small timestep limit (e.g., .01pS) for accuracy,
//     if bound_step() is not supported by your simulator.

`include "disciplines.vams"
`include "constants.vams"

`ifdef insideADMS
    `define P(txt) (*txt*)
`else
    `define P(txt)
`endif

// This enables series inductance modeling with the LSER parameter.
`define NEWLSER

// Enable addition of external shunt conductance.
`define NEWVSHUNT

// Enable series inductance modeling of external shunt resistance.
`ifdef NEWVSHUNT
`define NEWLSH
`endif

// Enable the 'n' SFQ emission count parameter.  Can comment this if
// you don't do SFQ logic.
`define NEWNPAR

// Suppress limit check of subgap and normal resistances.  Not
// recomended unless needed for Monte Carlo or weird devices.
//`define NORLMT

// Avoid calling the idt (integration) function, seems it may be
// inaccurate in some implementations.  This seems to reduce
// iterations and run time in WRspice too, so now defaulting to on.
`define NOIDT

// MIT-LL SFQ5EE process, parameters from:
// Tolpygo et al., IEEE Trans. Appl. Supercond., vol. 26, 1100110, (2016)
// Tolpygo et al., IEEE Trans. Appl. Supercond., vol. 27, 1100815, (2017)
`define C_PER_A_10000  70.0     // ff/um2
`define I_PER_A_10000 100.0     // uA/um2
`define IcR_LL          1.65    // mV, critical current * normal resistance
`define Vm_LL          16.5     // mV, critical current * subgap resistance

// Hard-wire defaults for MIT-LL process for SuperTools.
`define C_PER_A `C_PER_A_10000
`define I_PER_A `I_PER_A_10000
`define IcR     `IcR_LL
`define Vm      `Vm_LL

// Various Hypres foundry processes.
//`define C_PER_A_4500   59.0     // ff/um2
//`define I_PER_A_4500   45.0     // uA/um2
//`define C_PER_A_1000   50.0     // ff/um2
//`define I_PER_A_1000   10.0     // uA/um2
//`define C_PER_A_30     37.0     // ff/um2
//`define I_PER_A_30      0.3     // uA/um2
//`define IcR_HYP         1.7     // mV, critical current * normal resistance
//`define Vm_HYP         30.0     // mV, critical current * subgap resistance

// Hard-wire defaults for Hypres 4500A/cm2 process
//`define C_PER_A `C_PER_A_4500
//`define I_PER_A `I_PER_A_4500
//`define IcR     `IcR_HYP
//`define Vm      `Vm_HYP

// Phi0/2pi = hbar over 2 e.
`define PHI0_2PI    3.29105978475453e-16
`ifdef WRspice
`define BOLTZ       1.3806226e-23
`define ECHG        1.602176634e-19
`else
`define bcs_egapv(t, tc, f, d) (d*tanh(f*sqrt(tc/(t + 1e-4))))
`endif

module tjm (n1, n2, ph);

// The third node is optional, and if used will return the junction phase
// in radians.
inout n1, n2, ph;
// Add flags to indicate a "phase node" for WRspice phase-mode DC analysis.
electrical n1           `P(phase="true");
electrical n2           `P(phase="true");
electrical ph;
`ifdef NEWLSER
electrical nint         `P(phase="true");
branch(nint, n2) bj, bc, br;
branch(n1, nint) blser;
`else
branch(n1, n2) bj, bc, br;
`endif
`ifdef NEWLSH
electrical nshint       `P(phase="true");
`endif
`ifdef NOIDT
electrical nph;
`endif

//
// Model Parameters
//

parameter integer cct   = 1 from [0:1]
    `P(type="model" info="Critical current model type");

// Temperature correction
parameter real tc1      = 9.26 from [0.1:280]
    `P(type="model" info="Superconducting trans temp 1 Kelvin");
parameter real tc2      = 9.26 from [0.1:280]
    `P(type="model" info="Superconducting trans temp 2 Kelvin");
parameter real tc       = 9.26 from [0.1:280]
    `P(type="model" info="Superconducting trans temp Kelvin");
parameter real tnom     = 4.2 from [0.0:tc]
    `P(type="model" info="Parameter measurement temperature Kelvin");
parameter real temp     = tnom from [0.0:tc]
    `P(type="model" info="Operating temperature Kelvin");
`ifdef WRspice
// WRspice has support for computing gap potential given Debye temperature
// and Tc for a BCS superconductor and temperature ($bcs_egapv).
parameter real tdb1     = 276 from [40:500]
    `P(type="model" info="Debye temperature 1 Kelvin");
parameter real tdb2     = 276 from [40:500]
    `P(type="model" info="Debye temperature 2 Kelvin");
`else
// Use a fitting formula with given deltas at T=0 for temperature dep.
parameter real tcfct    = 1.74 from [1.5:2.5]
    `P(type="model" info="Temperature correction parameter");
parameter real del01    = 1.4m from [.05m:5m]
    `P(type="model" info="Energy gap 1 at T=0" units="V");
parameter real del02    = 1.4m from [.05m:5m]
    `P(type="model" info="Energy gap 2 at T=0" units="V");
`endif

// Factor used in timestep control.  This is similar to the WRspice
// dphimax parameter, dphimax/(2*pi) = tsfactor.  Smaller values might
// improve accuracy, but at the expense of longer run time.  If not
// set explicitly, actual value will be obtained from WRspice.
parameter real tsfactor = 0.1 from [0.001:1]
    `P(type="model" info="Phase change max per time step per 2pi");

// Use longer time steps when JJ voltage is smaller, a value of about
// 2.5 seems to work best for RSFQ.
parameter real tsaccel = 1.0 from [1.0:20.0]
    `P(type="model" info="Ratio max time step to that at dropback voltage");

// Critical current for area=1.
parameter real icrit    = 1.0m from [1e-9:1e-1]
    `P(type="model" info="Reference critical current" units="A");

// Capacitance per critical current, F/A.
parameter real cpic     = 1e-9*`C_PER_A/`I_PER_A from [0.0:1e-6]
    `P(type="model" info="Reference capacitance per critical current"
    units="F/A");

// Capacitance for area=1.
parameter real cap      = icrit*cpic from [0.0:1e-6*icrit]
    `P(type="model" info="Reference capacitance" units="F");

// Capacitance scaling parameter.
// caps = cap*(area*(1-cmu) + sqrt(area)*cmu)
parameter real cmu      = 0.0 from [0.0:1.0]
    `P(type="model" info="Capacitance scaling factor");

// Ratio of critical current to quasiparticle step height.
parameter real icfct    = `M_PI_4 from [0.5:`M_PI_4]
    `P(type="model" info="Ic to Istep ratio");
aliasparam icfact       = icfct;

`ifdef NORLMT
parameter real vm       = `Vm*1e-3 from (0:1e6]
    `P(type="model" info="Ic * subgap resistance" units="V");
parameter real rsub     = vm/icrit from (0:1e6]
    `P(type="model" info="Subgap resistance" units="O");
`else
parameter real vm       = `Vm*1e-3 from [8m:100m]
    `P(type="model" info="Ic * subgap resistance" units="V");
parameter real rsub     = vm/icrit from [8e-3/icrit:1e-1/icrit]
    `P(type="model" info="Subgap resistance" units="O");
`endif
aliasparam r0           = rsub;
`ifdef NEWVSHUNT
// The subgap and normal resistances.  If vshunt is given, a fixed
// shunt is added so that Ic*Reff = vshunt.
parameter real vshunt   = 0 from [0:3m]
    `P(type="model" info="Ic * shunt resistance voltage" units="V");
`endif
`ifdef NEWLSH
parameter real lsh0   = 0 from [0:2p]
    `P(type="model" info="Shunt inductance constant part" units="H");
parameter real lsh1   = 0 from [0:10p]
    `P(type="model" info="Shunt inductance prop. to resistance" units="H/Ohm");
`endif

// Conductance scaling parameter.
// gxs = gx*(area*(1-gmu) + sqrt(area)*gmu)
// Applies ro rsub.
parameter real gmu      = 0.0 from [0.0:1.0]
    `P(type="model" info="Conductance scaling factor");

//
// Instance Parameters
//

// Initial conditions.
parameter real ic_phase = 0 from (-`M_PI:`M_PI)
    `P(type="instance" info="Initial condition phase");
aliasparam phi          = ic_phase;

// Scaling critical current.
parameter real ics      = icrit from [icrit/50:icrit*50]
    `P(type="instance" info="Scaled critical current" units="A");

`ifdef NEWLSER
// Series inductance.
parameter real lser     = 0.0 from [0.0:10.0p]
    `P(type="instance" info="Series parasitic inductance" units="H");
`endif

`ifdef NEWLSH
parameter real lsh      = 0.0 from [0.0:100.0p]
    `P(type="instance" info="Series inductance of shunt resistance" units="H");
`endif

// Scaling factor, not a physical area.  This is for backward
// compatibility.
// *** Deprecated, do not use in new work ***
// Use ics instead, as the instance critical current won't change if
// the reference critical current does change.
parameter real area     = 1.0 from [0.05:20.0]
    `P(type="instance" info="Ic scale factor");

// Internal variables.  Those with `P() given are accessible in WRspice
// as read-only parameters (ADMS feature).
real vdpbak `P(type="model" info="Dropback voltage");
real omegaJ `P(type="model" info="Plasma frequency");
real betac `P(type="model" info="Stewart-McCumber parameter");
real vgap `P(type="model" info="Gap voltage" units="V");
real del1 `P(type="model" info="Energy gap 1" units="V");
real del2 `P(type="model" info="Energy gap 2" units="V");

integer tjm_narray `P(type="model" info="");
real tjm_alphaN `P(type="model" info="");
real tjm_kgap `P(type="model" info="");
real tjm_rejpt `P(type="model" info="");
real tjm_kgap_rejpt `P(type="model" info="");

real P_r[0:7];
real P_i[0:7];
real A_r[0:7];
real A_i[0:7];
real B_r[0:7];
real B_i[0:7];

integer i;

real tcf `P(type="instance" info="Temperature ic correction factor");
real phase `P(type="instance" info="Junction phase");
`ifdef NEWNPAR
integer n `P(type="instance" info="SFQ emission count");
`endif
real caps `P(type="instance" info="Device capacitance");
real scale `P(type="instance" info="Area ratio");
real ic_scaled `P(type="instance" info="Scaled and temp. compensated Ic");;
real rsubs `P(type="instance" info="Device sub-gap resistance");
`ifdef NEWVSHUNT
real gshunt `P(type="instance" info="External VSHUNT shunt conductance");
`ifdef NEWLSH
real lshval `P(type="instance" info="Shunt resistor parasitic inductance");
`endif
`endif

// Per-instance variables.
real lasttime;
real tjm_sinphi_2_old;
real tjm_cosphi_2_old;
real tjm_gcrit;
real tjm_Fc_r[0:11];
real tjm_Fc_i[0:11];
real tjm_Fs_r[0:11];
real tjm_Fs_i[0:11];
real tjm_Fcprev_r[0:11];
real tjm_Fcprev_i[0:11];
real tjm_Fsprev_r[0:11];
real tjm_Fsprev_i[0:11];
real tjm_alpha0_r[0:11];
real tjm_alpha0_i[0:11];
real tjm_alpha1_r[0:11];
real tjm_alpha1_i[0:11];
real tjm_exp_z_r[0:11];
real tjm_exp_z_i[0:11];

real i1, i2, vth, start_phase, tsf;
`ifdef WRspice
real SmallSigL;
integer pmode;
`endif

analog begin

// Differentiate between model and instance initialization blocks when
// using ADMS.  This allows model and instance parameters to apply to
// models and instances, respectively, for space efficiency.  Other
// compilers may use a unified model where all parameters can apply to
// instances or models, which is sometimes convenient but very memory
// intensive.

`ifdef insideADMS
    begin : initial_model
        real halfvg;
`else
    @(initial_step)
        begin : initialization
        real halfvg;
        real halfdv;
`endif
        // Mitmojco  BCS42_008 and NbNb_4K2_008
        P_r[0] = -4.373312;
        P_r[1] = -0.411779;
        P_r[2] = -0.139858;
        P_r[3] = -0.013048;
        P_r[4] = -0.043182;
        P_r[5] = -1.105852;
        P_r[6] = -0.651673;
        P_r[7] = -0.073309;
        P_i[0] = -0.114845;
        P_i[1] = 0.898335;
        P_i[2] = 0.991853;
        P_i[3] = 1.000349;
        P_i[4] = 1.000747;
        P_i[5] = -0.000000;
        P_i[6] = 0.123645;
        P_i[7] = 0.000067;
        A_r[0] = 1.057436;
        A_r[1] = 0.219525;
        A_r[2] = 0.077953;
        A_r[3] = 0.006675;
        A_r[4] = 0.025091;
        A_r[5] = 1.376607;
        A_r[6] = -0.459333;
        A_r[7] = -0.000889;
        A_i[0] = -18.941930;
        A_i[1] = 0.072188;
        A_i[2] = 0.007944;
        A_i[3] = -0.000475;
        A_i[4] = 0.000289;
        A_i[5] = -0.000002;
        A_i[6] = -0.152676;
        A_i[7] = -0.041516;
        B_r[0] = 0.108712;
        B_r[1] = 0.109049;
        B_r[2] = 0.072237;
        B_r[3] = 0.006656;
        B_r[4] = 0.025316;
        B_r[5] = -0.217956;
        B_r[6] = -0.401859;
        B_r[7] = 0.000643;
        B_i[0] = 7.209623;
        B_i[1] = 0.238592;
        B_i[2] = 0.029470;
        B_i[3] = -0.000208;
        B_i[4] = 0.002275;
        B_i[5] = 0.000001;
        B_i[6] = -0.545156;
        B_i[7] = -0.098458;
        tjm_narray = 8;

`ifdef WRspice
        del1 = $bcs_egapv(temp, tc1, tdb1);
        del2 = $bcs_egapv(temp, tc2, tdb2);
`else
        del1 = bcs_egapv(temp, tc1, tcfct, del01);
        del2 = bcs_egapv(temp, tc2, tcfct, del02);
`endif
        vgap = del1 + del2;
        if (temp != tnom)
            begin
            real vgnom, tmp, tmp2;
`ifdef WRspice
            vgnom = $bcs_egapv(tnom, tc1, tdb1) + $bcs_egapv(tnom, tc2, tdb2);
`else
            vgnom = bcs_egapv(tnom, tc1, tcfct, del01) +
                bcs_egapv(tnom, tc2, tcfct, del02);
`endif
            tmp = `ECHG*vgap/(4.0*`BOLTZ*(temp + 1e-4));
            tmp2 = `ECHG*vgnom/(4.0*`BOLTZ*(tnom + 1e-4));
            tcf = (vgap/vgnom)*(tanh(tmp)/tanh(tmp2));
            end
        else
            tcf = 1.0;

        // Dropback voltage.
        begin
        halfvg = 0.5*vgap;
        if (cap > 0.0)
            begin
            vdpbak = sqrt(`PHI0_2PI*icrit/cap);
            if (vdpbak > halfvg)
                vdpbak = halfvg;
            omegaJ = sqrt(icrit/(cap*`PHI0_2PI));
            end
        else
            vdpbak = halfvg;
        vth = vdpbak/tsaccel;
        end

        tjm_kgap = (0.5*vgap/`PHI0_2PI)/omegaJ;
        tjm_rejpt = 0.0;
        for (i = 0;  i < tjm_narray; i = i+1) begin
            real cr, bmg;
            bmg = P_r[i]*P_r[i] + P_i[i]*P_i[i];
            cr = (A_r[i]*P_r[i] + A_i[i]*P_i[i])/bmg;
            tjm_rejpt = tjm_rejpt - cr;
//$display("%g %g %g %g %g\n", tjm_rejpt, A_r[i], A_i[i], P_r[i], P_i[i]);
        end
        tjm_rejpt = tjm_rejpt*icfct;
        tjm_kgap_rejpt = tjm_kgap/tjm_rejpt;
        tjm_alphaN = 1.0/(2*tjm_rejpt*tjm_kgap);

        // Renormalize.  Here we would rotate to C and D vectors,
        // however we want to preserve the pair and qp amplitudes for
        // separate access.
        for (i = 0;  i < tjm_narray; i = i+1) begin
            real cr, ci, bmg;
            bmg = P_r[i]*P_r[i] + P_i[i]*P_i[i];
            cr = (A_r[i]*P_r[i] + A_i[i]*P_i[i])/bmg;
            ci = (A_i[i]*P_r[i] - A_r[i]*P_i[i])/bmg;
            A_r[i] = -cr*icfct/tjm_kgap;
            A_i[i] = -ci*icfct/tjm_kgap;
            cr = (B_r[i]*P_r[i] + B_i[i]*P_i[i])/bmg;
            ci = (B_i[i]*P_r[i] - B_r[i]*P_i[i])/bmg;
            B_r[i] = -cr/tjm_kgap;
            B_i[i] = -ci/tjm_kgap;
//$display("%g %g %g %g\n", A_r[i], A_i[i], B_r[i], B_i[i]);
        end

        // dphiMax
        //   If simulator returns nonzero, the dphimax .option is
        //   supported and the value returned.  This is the maximum
        //   phase change per internal time step.  The local default
        //   is used if not supported by the simulator.
        //   Requires WRspice-4.3.3.
        //
        tsf = $simparam("dphiMax", 0.0)/(2*`M_PI);
        if (tsf < 1e-3 || $param_given(tsfactor))
            tsf = tsfactor;
`ifdef insideADMS
    end

    begin : initial_instance
        real halfdv;
`endif

        lasttime = 0.0;

        begin
        real tvm;
        tvm = vm*tcf;
        betac = tvm*tvm*cap/(icrit*`PHI0_2PI);
        end

        if (ics != icrit)
            begin
            scale = ics/icrit;
            ic_scaled = tcf*ics;
            end
        else
            begin
            scale = area;
            ic_scaled = tcf*scale*icrit;
            end

        caps = cap*(scale*(1-cmu) + sqrt(scale)*cmu);
        rsubs = rsub/(scale*(1-gmu) + sqrt(scale)*gmu);
        start_phase = ic_phase;
        phase = start_phase;
        tjm_sinphi_2_old = sin(0.5*phase);
        tjm_cosphi_2_old = cos(0.5*phase);
        for (i = 0; i < tjm_narray; i = i+1) begin
            tjm_Fc_r[i] = 0.0;
            tjm_Fc_i[i] = 0.0;
            tjm_Fs_r[i] = 0.0;
            tjm_Fs_i[i] = 0.0;
            tjm_Fcprev_r[i] = tjm_cosphi_2_old;
            tjm_Fcprev_i[i] = 0.0;
            tjm_Fsprev_r[i] = tjm_sinphi_2_old;
            tjm_Fsprev_i[i] = 0.0;
            tjm_alpha0_r[i] = 0.0;
            tjm_alpha0_i[i] = 0.0;
            tjm_alpha1_r[i] = 0.0;
            tjm_alpha1_i[i] = 0.0;
            tjm_exp_z_r[i] = 0.0;
            tjm_exp_z_i[i] = 0.0;
        end

`ifdef WRspice
        SmallSigL = 0.0;
`endif
`ifdef NEWVSHUNT
        gshunt=0.0;
`ifdef NEWLSH
        lshval=0.0;
`endif
        if (vshunt >= 1u)
            begin
            gshunt = ic_scaled/vshunt;
`ifdef NEWLSH
            if (gshunt > 0)
                if (lsh != 0.0)
                    lshval = lsh;
                else if (lsh0 != 0.0 || lsh1 != 0.0)
                    lshval = lsh0 + lsh1/gshunt;
`endif
            end
`endif  // NEWVSHUNT

        // Interface parameter passed to model from simulator using
        // the Verilog $simparam system function.  At present, only
        // WRspice supports this.
        //
        // dcPhaseMode
        //   If simulator returns nonzero, it supports phase-mode DC
        //   analysis.  Requires WRspice-4.3.3.
        //
`ifdef WRspice
        pmode = (cct > 0 && $simparam("dcPhaseMode", 0.0) > 0);
`endif
    end

`ifdef WRspice
    // Only WRspice can do DC analysis at present.

    if (analysis("static") != 0)
        begin

        // smallSig
        //   If the simulator returns nonzero, we're about to load the
        //   small-signal values for AC and similar analysis.
        //   Requires WRspice-4.3.4.
        //
        if ($simparam("smallSig", 0.0) != 0.0)
            begin : smallSig

            // We're through with phase mode, call the regular load
            // functions.

            if (cct > 0)
                I(bj) <+ ic_scaled*sin(phase);

            // Geometric capacitance current.
            I(bc) <+ ddt(caps*V(bc));
`ifdef NEWLSER
            if (lser > 0.0)
                V(blser) <+ ddt(lser*I(blser));
            else
                V(blser) <+ 0.0;
`endif

            // Small-signal inductance of Josephson current.  This is
            // a hack for ADMS - an instance variable of this name is
            // treated specially in the AC load function.  ADMS does
            // not recognize the small signal inductance from the
            // expressions above, so we have to do this explicitly.
            // Perhaps other parsers will handle this correctly?
            //
            SmallSigL = `PHI0_2PI/(ic_scaled*cos(phase));

            // Quasiparticle current, piecewise-linear model.

`ifdef NEWVSHUNT
            if (vshunt > 1u)
                begin
`ifdef NEWLSH
                if (lsh > 0.0 || lsh0 > 0.0 || lsh1 > 0.0)
                    V(n1,nshint) <+ ddt(lshval*I(n1,nshint));
                else
                    V(n1,nshint) <+ 0.0;
                I(nshint,n2) <+ gshunt*V(nshint,n2);
`else
`ifdef NEWLSER
                I(n1,n2) <+ gshunt*V(n1,n2);
`else
                I(br) <+ gshunt*V(br);
`endif
`endif  // NEWLSH
                end
`endif  // NEWVSHUNT

`ifdef NOIDT
            if ($port_connected(ph))
                V(nph,ph) <+ 0;
            I(nph) <+ phase;
            I(nph) <+ -V(nph);
`else
            if ($port_connected(ph))
                begin
                I(ph) <+ phase;
                I(ph) <+ -V(ph);
                end
`endif
            end
        else if (pmode != 0)
            begin
            // DC analysis, the simulator supports phase mode DC
            // analysis.  In this mode, the nodes connected to JJs and
            // inductors are "phase nodes", and the "voltage" at these
            // nodes is actually the phase with respect to ground.
            // Resistors are treated specially, they are the bridge
            // between phase nodes and voltage nodes.  When loading
            // the circuit matrix for a resistor, if both nodes are
            // voltage-type or ground, the resistance is loaded
            // normally.  If both nodes are phase-type or ground, the
            // resistor is not loaded at all.  If the resistor
            // connects between a phase node and a voltage node, the
            // resistor is loaded on the voltage node as if connected
            // to ground.  A term that looks like a voltage-controlled
            // current source injects current into the phase node,
            // with value of the voltage node voltage over the
            // resistance.  Then, a standard SPICE DCOP or DC sweep
            // can be run, yielding all DC circuit values.
            //
            // Note that there is at present a topological constraint
            // that all phase nodes must be at ground potential, so
            // networks of inductors/JJs must have a ground connection
            // somewhere.  Also, one may need to introduce resistors
            // in some cases:  consider a JJ circuit driving a CMOS
            // comparator.  If the comparator gate is connected
            // directly to a JJ, during the DC analysis the comparator
            // will see the phase voltage.  If instead, the comparator
            // is connected through a resistor of any value, the
            // comparator input will be set to zero during DC
            // analysis, which is correct.
            //
            // Below, we can ignore the conductance terms (phase nodes
            // on both ends), and of course capacitors are ignored in
            // DC analysis.

            phase = V(bj);
            if (cct == 1)
                I(bj) <+ ic_scaled*sin(phase);
            start_phase = phase;
`ifdef NOIDT
            if ($port_connected(ph))
                V(nph,ph) <+ 0;
            I(nph) <+ phase;
            I(nph) <+ -V(nph);
`else
            if ($port_connected(ph))
                begin
                I(ph) <+ phase;
                I(ph) <+ -V(ph);
                end
`endif
`ifdef NEWLSER
            if (lser > 0.0)
                V(blser) <+ lser*I(blser)/`PHI0_2PI;
            else
                V(blser) <+ 0.0;
`endif
`ifdef NEWLSH
            if (lsh > 0.0 || lsh0 > 0.0 || lsh1 > 0.0)
                V(n1,nshint) <+ lshval*I(n1,nshint)/`PHI0_2PI;
            else
                V(n1,nshint) <+ 0.0;
`endif
            end
        else
            begin
            $error(
 "TJM.va model:  DC analysis is unsupported, use \"uic\" to avoid DCOP.");
            $finish(0);
            end
        end

    else if (analysis("tran") != 0)
`else  // not WRspice
    if (analysis("tran") != 0)
`endif  // WRspice

        begin : tranan

        if ($realtime != lasttime)
            // new_step
            begin
            real kdt;
            kdt = tjm_kgap*omegaJ*($realtime - lasttime);
            lasttime = $realtime;

            // accept
            tjm_sinphi_2_old = sin(0.5*phase);
            tjm_cosphi_2_old = cos(0.5*phase);

//$display("  %g %g\n", $realtime, kdt);
            for (i = 0; i < tjm_narray; i = i+1)
                begin
                real z_r, z_i, d, ez_r, ez_i, mz, zt_r, zt_i;
                z_r = P_r[i]*kdt;
                z_i = P_i[i]*kdt;
                d = exp(z_r);
                ez_r = d*cos(z_i);
                ez_i = d*sin(z_i);
                tjm_exp_z_r[i] = ez_r;
                tjm_exp_z_i[i] = ez_i;
                mz = z_r*z_r + z_i*z_i;
                zt_r = ((ez_r - 1.0)*z_r + ez_i*z_i)/mz;
                zt_i = (-(ez_r - 1.0)*z_i + ez_i*z_r)/mz;
                tjm_alpha0_r[i] = zt_r - ez_r;
                tjm_alpha0_i[i] = zt_i - ez_i;
                tjm_alpha1_r[i] = 1.0 - zt_r;
                tjm_alpha1_i[i] = -zt_i;
//$display("%g %g %g %g\n", tjm_alpha0_r[i], tjm_alpha0_i[i], tjm_alpha1_r[i], tjm_alpha1_i[i]);

                // accept
                tjm_Fcprev_r[i] = tjm_Fc_r[i];
                tjm_Fcprev_i[i] = tjm_Fc_i[i];
                tjm_Fsprev_r[i] = tjm_Fs_r[i];
                tjm_Fsprev_i[i] = tjm_Fs_i[i];
                end
            end

`ifdef NOIDT
        // Integrate using the charge on a virtual capacitor.
        // This assumes that ddt is not broken as is idt.

        if ($port_connected(ph))
            V(nph,ph) <+ 0;
        phase = V(nph);
        I(nph) <+ -V(bj);
        I(nph) <+ ddt(V(nph)*`PHI0_2PI);
        // Keep a dc return path or matrix might be singular.
        I(nph) <+ 1e-12;
        // I(nph) <+ $simparam("gmin", 1e-12);  // may be slow
`else
        phase = idt(V(bj)/`PHI0_2PI, start_phase);
        if ($port_connected(ph))
            begin
            // The following will make the output phase node look like
            // a voltage source.  However, some Verilog-A translation
            // systems can't handle this construct (WRspice handles it
            // properly).  It also adds a "branch" node to the circuit
            // matrix, which increases memory use for no good reason.
            //
            // V(ph) <+ phase;
            //
            // The following is basically equivalent.  This gives our
            // "voltage source" a 1 ohm internal resistance, and does
            // not increase the circuit matrix size.
            //
            I(ph) <+ phase;
            I(ph) <+ -V(ph);
            end
`endif

        // Geometric capacitance current.
        I(bc) <+ ddt(caps*V(bc));

        // Quasiparticle current, piecewise-linear model.

`ifdef NEWVSHUNT
        if (vshunt > 1u)
            begin
`ifdef NEWLSH
            if (lsh > 0.0 || lsh0 > 0.0 || lsh1 > 0.0)
                V(n1,nshint) <+ ddt(lshval*I(n1,nshint));
            else
                V(n1,nshint) <+ 0.0;
            I(nshint,n2) <+ gshunt*V(nshint,n2);
`else
`ifdef NEWLSER
            I(n1,n2) <+ gshunt*V(n1,n2);
`else
            I(br) <+ gshunt*V(br);
`endif
`endif  // NEWLSH
            end
`endif  // NEWVSHUNT

`ifdef NEWLSER
        if (lser > 0.0)
            V(blser) <+ ddt(lser*I(blser));
        else
            V(blser) <+ 0.0;
`endif

        begin : update
        real sinphi_2, cosphi_2, FcSp, FcSq, FsSp, FsSq, fct;
        sinphi_2 = sin(0.5*phase);
        cosphi_2 = cos(0.5*phase);
        FcSp = 0.0;  // cosine for pairs
        FcSq = 0.0;  // cosine for qp
        FsSp = 0.0;  // sine for pairs
        FsSq = 0.0;  // sine for qp
        for (i = 0; i < tjm_narray; i = i+1)
            begin
            //tjm_Fc[i] = tjm_exp_z[i]*tjm_Fcprev[i] +
            //    tjm_alpha0[i]*tjm_cosphi_2_old + tjm_alpha1[i]*cosphi_2;
            //tjm_Fs[i] = tjm_exp_z[i]*tjm_Fsprev[i] +
            //    tjm_alpha0[i]*tjm_sinphi_2_old + tjm_alpha1[i]*sinphi_2;

            tjm_Fc_r[i] = tjm_exp_z_r[i]*tjm_Fcprev_r[i] -
                tjm_exp_z_i[i]*tjm_Fcprev_i[i] +
                tjm_alpha0_r[i]*tjm_cosphi_2_old +
                tjm_alpha1_r[i]*cosphi_2;
            tjm_Fc_i[i] = tjm_exp_z_r[i]*tjm_Fcprev_i[i] +
                tjm_exp_z_i[i]*tjm_Fcprev_r[i] +
                tjm_alpha0_i[i]*tjm_cosphi_2_old +
                tjm_alpha1_i[i]*cosphi_2;
            tjm_Fs_r[i] = tjm_exp_z_r[i]*tjm_Fsprev_r[i] -
                tjm_exp_z_i[i]*tjm_Fsprev_i[i] +
                tjm_alpha0_r[i]*tjm_sinphi_2_old +
                tjm_alpha1_r[i]*sinphi_2;
            tjm_Fs_i[i] = tjm_exp_z_r[i]*tjm_Fsprev_i[i] +
                tjm_exp_z_i[i]*tjm_Fsprev_r[i] +
                tjm_alpha0_i[i]*tjm_sinphi_2_old +
                tjm_alpha1_i[i]*sinphi_2;

            FcSp = FcSp + A_r[i]*tjm_Fc_r[i] - A_i[i]*tjm_Fc_i[i];
            FcSq = FcSq + B_r[i]*tjm_Fc_r[i] - B_i[i]*tjm_Fc_i[i];
            FsSp = FsSp + A_r[i]*tjm_Fs_r[i] - A_i[i]*tjm_Fs_i[i];
            FsSq = FsSq + B_r[i]*tjm_Fs_r[i] - B_i[i]*tjm_Fs_i[i];
//$display("%g %g %g %g\n", tjm_Fc_r[i], tjm_Fc_i[i], tjm_Fs_r[i], tjm_Fs_i[i]);
            end
        fct = ic_scaled*tjm_kgap_rejpt;
        if (cct > 0)
            begin
            I(bj) <+ fct*(sinphi_2*FcSp + cosphi_2*FsSp);
            tjm_gcrit = tjm_alphaN * sqrt(caps*ic_scaled/`PHI0_2PI);
            I(bj) <+ V(bj)*tjm_gcrit;
            end
        I(br) <+ fct*(sinphi_2*FcSq - cosphi_2*FsSq);
        I(br) <+ V(br)/rsubs;
        end

        // Limit time step.  This is important, as the simulator may have
        // no other way to recognize the supercurrent and plasma
        // oscillation and limit the time step accordingly.
        //
        begin : tslimit
        real vtmp;
        vtmp = abs(V(br));
        if (vtmp < vth)
            vtmp = vth;
        $bound_step(2*`M_PI*tsf*`PHI0_2PI/vtmp);
        end

`ifdef NEWNPAR
        // Compute the SFQ emission count, used for pass/fail testing
        // of SFQ circuits.
        begin : nparblk
        real pp, twopi;
        integer pint;
        twopi = `M_PI + `M_PI;
        if (phase >= 0.0)
            begin
            pint = phase/twopi;
            pp = phase - pint*twopi;
            if (pp > `M_PI + `M_PI_4)
                pint = pint + 1;
            end
        else
            begin
            pint = phase/twopi;
            pp = phase - pint*twopi + twopi;
            if (pp < `M_PI - `M_PI_4)
                pint = pint - 1;
            end
        n = abs(pint);
        end
`endif
        end

    else
        begin
        $error("TJM.va model:  unknown or unsupported analysis.");
        $finish(0);
        end
end
endmodule
