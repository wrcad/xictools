/***************************************************
 *
 * Corner Tool Support
 *
 ***************************************************/

/*********************************************************************
 *
 *  Public code/PI to support corner analysis
 *
 *********************************************************************/

/*********************************************************************
 * asiGetCornerModelingStyles( o_session ) => l_cornList
 * Returns the list of supported Modeling Styles.
 *********************************************************************/

defmethod( asiGetCornerModelingStyles (( session WRspice_session))
   ;; Define these two modeling styles as the default ones for 3rd party Sims
   '("singleModelLib" "singleNumeric")
)

/*********************************************************************
 * asiCornerSimCB( o_session ) => l_cornList
 * Call Back routine, that's called on successful completion of all
 * Corner Simulation Runs. The template code provided here is used
 * to re-organize the Corner's simulation data for different Corner Runs
 * into different 'Corner' folders. This re-organization is required for
 * 'singleModelLib' modeling style with Alter Mode set to ON.
 *
 * Integrator should change use this as a guideline only and change this
 * according to their simulator output for a ALTER RUN SIMULATION.
 *
 * It's Assumed here that for a ALTER netlist on 'n' Corners, simulator
 * will be run for 'n+1' time, one for normal settings and one per Corner.
 * So as a result, following set of files will be generated by the simulator
 * in the psf folder:
 *
 *  - analysisAC1.ac, analysisDC1.dc, analysisTran1.tran for normal RUN
 *  - analysisAC2.ac, analysisDC2.dc, analysisTran2.tran for first Corner RUN
 *         -- These files have to be moved from 'psf' folder to 'Corner/cor_1'
 *  - analysisAC3.ac, analysisDC3.dc, analysisTran3.tran for second Corner RUN and so on ...
 *         -- These files have to be moved from 'psf' folder to 'Corner/cor_i'
 *
 *  - artistLogFile, simRunData, variables_file for simulation data access
 *         -- These files have to be copied to every 'Corner/cor_i' folder.
 *
 *  - 'logFile' file is generated by the simulator while dumping the PSF data
 *            This file contains the information about the simulation data file
 *            names corresponding to each of the analysis RUN by the Simulator.
 *            For accessing the simulation data, we need to have an equivalent
 *            file in each of the 'Corner/cor_i' folder containg the information
 *            about the simulation data files for that Corner RUN.
 *            We need little post-processing on this parent 'logFile' present in
 *            'psf' folder and generate child 'logFile' for each of the Corners.
 *
 *  - 'runObjFile' file is generated by the ADE/OASIS environment. This is
 *            required for the data access for the family of simulation data
 *            corresponding to each of the Corners.
 *            Apart from this parent 'runObjFile', we need to generate child
 *            'runObjFile' for each of the Corners.
 *
 *********************************************************************/

defmethod( asiCornerSimCB (( session  WRspice_session ))
 (let ((retVal nil) ( cornerList reverse(asiGetCornerList( session ))) (psfPath asiGetPsfDir(session)) corPath (cornIdx 2) copyList analList inPort outPort line )

   ;; This Call back is provided to re-organise the Corner's simulation data
   ;; for different Corner Runs in case of 'singleModelLib' modeling style
   ;; with Alter Mode ON.
   ;; Integrators should tailtor this to suit their needs.
   when(and(cornerList asiGetEnvOptionVal(session 'useAltergroup))

     ;; 'copyList' -> list of files that will be copied as-is
     ;; from 'psf' folder to Corners/cor_i folders.
     copyList = '("simRunData" "artistLogFile" "variables_file" "runObjFile")

     ;; Retain/move the parent 'runObjFile' file present in 'psf' folder
     ;; (generated by OASIS environment) to 'runObjFile.bak'
     errset(renameFile(strcat(psfPath "/runObjFile") strcat(psfPath "/runObjFile.bak" )))

     ;; Generate the template 'runObjFile' (child) file in 'psf' folder.
     ;; This will be copied later to Corners/cor_i folders.
     asiCreateRunObjectFile(session)

     foreach( corner cornerList
       corPath=strcat(psfPath "/../Corners/")
       corPath=strcat(corPath get_pname( asiGetCornerName( corner )))

       ;; Create the 'Corner' folder
       unless( isDir(corPath) createDir(corPath))

       foreach( file copyList
          ;; Copy the basic files as-is from ./psf to the Corners/cor_i folder
          (system (sprintf nil "cp %s/%s %s" psfPath file corPath))
       ) ;; foreach

       ;; Construct the relevant list of analysis data files for a Corner run
       ;; Integrator should change this according to the name of files
       ;; generated by their simulators.
       sprintf(analList "analysisAC%d.ac analysisDC%d.dc analysisTran%d.tran" cornIdx cornIdx cornIdx)
       analList=parseString(analList)

       ;; Copy the analysis data files for that RUN into corresponding Corners/cor_i folder
       foreach( file setof( x getDirFiles(psfPath) member( x analList))
          errset(renameFile(strcat(psfPath "/" file) strcat(corPath "/" file)))
       ) ;; foreach

       ;; Process the ./psf/logFile and derive ./Corners/cor_i/logFile for every corner RUN
       inPort=infile(strcat(psfPath "/logFile"))
       outPort=outfile(strcat(corPath "/logFile") "w")

       ;; Get the HEADER & TYPE fields as-is from the base logFile (./psf/logFile)
       while( and( inPort outPort gets(line inPort) setq(line parseString(line)) nequal(car(line) "VALUE"))
          foreach(mapcar i line fprintf(outPort "%s " i))
          newline(outPort)
       ) ;; while
       fprintf(outPort "VALUE\n")

       ;; Filter the Relevant analysis information for that Corner RUN.
       while( and( inPort outPort setq(line lineread(inPort)))
          if( member(nth(1 nth(2 line)) analList)
            then
              ;; Translate the analysis name dumped by simulator to something
              ;; common for the same analysis type across all Corners.
              ;; This is required for letting the Result reader know that they
              ;; all (different simulation data analysisAC2.ac, analysisAC3.ac
              ;; and so on) belong to the same family.
              ;; So change the name from 'analysisAC1-ac', 'analysisAC2-ac'
              ;; and so on to common name 'analysis-ac'.
              fprintf(outPort "\"analysis-%s\" %L " nth(0 nth(2 line)) nth(1 line))
              ;; Print Rest of the analysis data as is
              printlev(nth(2 line) 10 100 outPort)
              newline(outPort)
          ) ;; if
       ) ;; while

       fprintf(outPort "END")
       close(inPort)
       close(outPort)
       postincrement(cornIdx)
     ) ;; foreach

     ;; Delete all the files in the 'psf' folder.
     copyList = cons( "logFile" copyList)
     foreach( file setof( x getDirFiles(psfPath) member( x copyList))
        deleteFile(strcat(psfPath "/" file))
     ) ;; foreach

     ;; Retain the original Parent 'runObjFile' file in 'psf' folder.
     errset(renameFile(strcat(psfPath "/runObjFile.bak") strcat(psfPath "/runObjFile" )))

     retVal=t
   ) ;; when
   retVal
 )
)

/*********************************************************************
 *
 *  Private code to support corner PI
 *
 *********************************************************************/

;; Integrators should modify the following functions according to their own simulators

defmethod( _WRspiceStartAlterKeyWord (( _session  WRspice_session ))
   "altergroup {"
)

defmethod( _WRspiceEndAlterKeyWord (( _session  WRspice_session ))
   "}"
)

defmethod( _WRspiceIncludeModelKeyWord (( _session  WRspice_session ))
   ".INCLUDE"
)

defmethod( _WRspiceParamDefineKeyWord (( _session  WRspice_session ))
   ".PARAM"
)

;; Internal function for testing, Integrators should not use this function.
defmethod( _WRspiceSwitchLang1 (( _session  WRspice_session ) fp)
  t
)

;; Internal function for testing, Integrators should not use this function.
defmethod( _WRspiceSwitchLang2 (( _session  WRspice_session ) fp)
  t
)
